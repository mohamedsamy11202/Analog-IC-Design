ADE simulation setup
Run mode: Single Run, Sweeps and Corners
Tests:
  Trining2:tb:1: Trining2/tb/schematic, simulator spectre
