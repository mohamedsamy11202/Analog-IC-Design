ADE simulation setup
Run mode: Single Run, Sweeps and Corners
Tests:
  Trining2:CS_AMPLIFER:1: Trining2/CS_AMPLIFER/schematic, simulator spectre
