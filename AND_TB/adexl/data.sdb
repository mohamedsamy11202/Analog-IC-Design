ADE simulation setup
Run mode: Single Run, Sweeps and Corners
Tests:
  Trining2:AND_TB:1: Trining2/AND_TB/schematic, simulator spectre
