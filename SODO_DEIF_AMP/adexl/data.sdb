ADE simulation setup
Run mode: Single Run, Sweeps and Corners
Tests:
  Trining2:SODO_DEIF_AMP:1: Trining2/SODO_DEIF_AMP/schematic, simulator spectre
