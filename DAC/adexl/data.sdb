ADE simulation setup
Run mode: Single Run, Sweeps and Corners
Tests:
  Trining2:DAC:1: Trining2/DAC/schematic, simulator spectre
Global variables:
  R = 1k
  RF = 47k
  V0 = 1
  V1 = 1
  V2 = 1
  V3 = 1
