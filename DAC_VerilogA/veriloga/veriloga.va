// VerilogA for Trining2, DAC_VerilogA, veriloga

`include "constants.vams"
`include "disciplines.vams"

module DAC_VerilogA(input x1,x2,x3,x4,output y);
	electrical x1,x2,x3,x4,y;
analog begin
V(y) <+ V(x1)*1;
V(y) <+ V(x2)*2;
V(y) <+ V(x3)*4;
V(y) <+ V(x4)*8;
end
endmodule
