ADE simulation setup
Run mode: Single Run, Sweeps and Corners
Tests:
  Trining2:DAC_TB:1: Trining2/DAC_TB/schematic, simulator spectre
