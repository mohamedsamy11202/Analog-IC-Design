ADE simulation setup
Run mode: Single Run, Sweeps and Corners
Tests:
  Trining2:P_Side:1: Trining2/P_Side/schematic, simulator spectre
Global variables:
  L = 2u
  VDS = 1.2
  VGS = 0
  W = 5*L
