ADE simulation setup
Run mode: Single Run, Sweeps and Corners
Tests:
  Trining2:MOSFET_CHAR:1: Trining2/MOSFET_CHAR/schematic, simulator spectre
Global variables:
  L = 2u
  VDS = 1.2
  VGS = 0:0.2:1.2
  W = 5*L
