ADE simulation setup
Run mode: Single Run, Sweeps and Corners
Tests:
  Trining2:NOT:1: Trining2/NOT/schematic, simulator spectre
