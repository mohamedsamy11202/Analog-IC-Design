ADE simulation setup
Run mode: Single Run, Sweeps and Corners
Tests:
  Trining2:AND:1: Trining2/AND/schematic, simulator spectre
