ADE simulation setup
Run mode: Single Run, Sweeps and Corners
Tests:
  Trining2:Assignment_1:1: Trining2/Assignment_1/schematic, simulator spectre
Global variables:
  VDS = 1.8
  VGS = 0:0.2:1.8
